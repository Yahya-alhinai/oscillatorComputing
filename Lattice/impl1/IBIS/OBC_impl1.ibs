| IBIS Models Generator: Lattice Diamond (64-bit) 3.11.0.396.4
| Generate date: Fri Feb 28 17:20:38 2020
| IBIS File machxo.ibs
| LibisGen v2.0.1.0, 02/25/2008, Lattice Semiconductor Corporation
| Modified by LibisMaker v2.0.1.0, 02/25/2008, Lattice Semiconductor
| North Carolina State University, ERL, 2006
[IBIS ver]   3.2
[File Name]   OBC_impl1.ibs
[File Rev]   2.2
[Date]   Mon Sep 28 10:44:10 EDT 2009
[Source]   Lattice Semiconductor EE12 Process
[Notes]   "Preliminary Version"
   Lattice Semiconductor has worked hard to ensure the
   models below are accurate and complete.  However, the
   data below was generated using simulation of the
   input/output model files for the silicon.  Therefore,
   the data below is for reference and initial design
   purposes only.
   The data below is correlated to Spice models.
   For questions regarding this data please contact
   us at www.latticesemi.com.
   Lattice Semiconductor grants permission to use this
   data for use in printed circuit design using this
   Lattice programmable logic device.  Other use of this
   code, including the selling or duplication of any
   portion is strictly prohibited.
|   NAMING CONVENTION
   The IBIS [Model] header is limited by the specification to a
   total of characters.  With such a set of characters available
   for naming models it becomes important to attempt to
   meaningfully encode the IO standards so they fit within the
   twenty character limit.  It would seem that twenty characters
   would provide room enough for describing IO's.  However, the
   PLD IO structure continues to grow more and more complex.  The
   complexity is making the twenty characters insuffiently
   descriptive.  In order to overcome this issue the naming
   convention described below is implemented to resolve the issue.
The twenty character space is managed as follows:
   bbbvvvsdddprugtcoixx
   b = standard
   v = voltage (x.xx V)
   s = slew code
   d = drive (xx.x ma)
   p = pullup code
   r = series resistance code
   u = terminate to vcc code
   g = terminate to gnd code
   t = terminate to vtt code
   c = common mode termination mode
   o = diff resistor code
   i = diff resistor current code
   x = reserved
   standard
   LVCMOS   lvc
   lvcmosd   lvd
   LVDSE   lve
   LVTTL   lvt
   lvttld   ltd
   PCI   pci
   pcix   pcx
   AGP1x   ag1
   agp2x   ag2
   sstl_I   ss1
   sstl_II   ss2
   sstld_I   s1d
   sstld_II   s2d
   CTT   ctt
   hstl_i   hs1
   hstl_ii   hs2
   hstl_iii   hs3
   hstl_iv   hs4
   hstld_i   h1d
   hstld_ii   h2d
   gtl   gtl
   gtlplus   gtp
   lvds   lvs
   blvds   blv
   mlvds   mlv
   lvpecl   lvp
   cml   cml
   hypt   hyp
   rsds   rsd
   vref1   vr1
   vref2   vr2
   ref_res   rer
   slew
   na   a
   fast   f
   slow   s
   pullmode
   off   a
   pullup   b
   pulldown   c
   bushold   d
   pciclamp   e
   up_pciclamp   f
   down_pciclamp   g
   keeper_pciclamp   h
   schmitt   i
   up_schmitt   j
   down_schmitt   k
   keeper_schmitt   l
   up_pciclamp_schmitt   m
   down_pciclamp_schmitt   n
   keeper_pciclamp_schmitt  o
   pciclamp_schmitt   p
   impedence
   off   a
   25   b
   33   c
   50   d
   100   e
   termVCC
   off   a
   50   b
   100   c
   120   d
   termGND
   off   a
   50   b
   100   c
   120   d
   termVTT
   off   a
   60   b
   75   c
   120   d
   150   e
   210   f
   VCMT
   off   a
   VCMT   b
   VTT   c
   DDR-2   d
   differential resistor
   off   a
   120   b
   150   c
   220   d
   420   e
   differential current
   NA   a
   2   b
   3.5   c
   4   d
   6   e
   Reserved   IO type
   in   input only
   ou   output
   io   I/O
   od   Open drain
   on   Inverting differential I/O
   (signal name only)
   op   Non-Inverting differential I/O
   (signal name only)
   All the IO models are generated with pull mode set to UP.
   Lattice Semiconductor Corporation
   5555 NE Moore Court
   Hillsboro, OR 97214
   U.S.A
   TEL: 1-800-Lattice (USA and Canada)
   408-826-6000 (other locations)
   web: http://www.latticesemi.com/
   email: techsupport@latticesemi.com
[Disclaimer] This IBIS source code is intended as a design reference
   which illustrates how the Lattice Semiconductor device operates.
   It is the user's responsibility to verify their design for
   consistency and functionality through the use of formal
   verification methods.  Lattice Semiconductor provides no warranty
   regarding the use or functionality of this data.
[Copyright]   Copyright 2009 by Lattice Semiconductor Corporation
|   Component XO
[Component]   MXO256_MXO640_MXO1K_MXO2K
[Manufacturer]   Lattice Semiconductor Corp.
[Package]
|TQFP144
| variable   typ   min   max
R_pkg   159.8m   143.8m   177.3m
L_pkg   7.50nH   6.44nH   8.48nH
C_pkg   1.22pF   1.06pF   1.38pF
[Pin] signal_name   model_name   R_pin   L_pin   C_pin
112   PMW_PIN[0]   lvc330f080baaaaaaaio
28   PMW_PIN[10]   lvc330f080baaaaaaaio
111   PMW_PIN[11]   lvc330f080baaaaaaaio
24   PMW_PIN[12]   lvc330f080baaaaaaaio
86   PMW_PIN[13]   lvc330f080baaaaaaaio
8   PMW_PIN[14]   lvc330f080baaaaaaaio
17   PMW_PIN[15]   lvc330f080baaaaaaaio
9   PMW_PIN[16]   lvc330f080baaaaaaaio
66   PMW_PIN[17]   lvc330f080baaaaaaaio
131   PMW_PIN[18]   lvc330f080baaaaaaaio
61   PMW_PIN[19]   lvc330f080baaaaaaaio
141   PMW_PIN[1]   lvc330f080baaaaaaaio
104   PMW_PIN[20]   lvc330f080baaaaaaaio
100   PMW_PIN[21]   lvc330f080baaaaaaaio
105   PMW_PIN[22]   lvc330f080baaaaaaaio
50   PMW_PIN[23]   lvc330f080baaaaaaaio
4   PMW_PIN[24]   lvc330f080baaaaaaaio
101   PMW_PIN[25]   lvc330f080baaaaaaaio
68   PMW_PIN[26]   lvc330f080baaaaaaaio
72   PMW_PIN[27]   lvc330f080baaaaaaaio
81   PMW_PIN[28]   lvc330f080baaaaaaaio
115   PMW_PIN[29]   lvc330f080baaaaaaaio
54   PMW_PIN[2]   lvc330f080baaaaaaaio
78   PMW_PIN[30]   lvc330f080baaaaaaaio
96   PMW_PIN[31]   lvc330f080baaaaaaaio
122   PMW_PIN[32]   lvc330f080baaaaaaaio
124   PMW_PIN[33]   lvc330f080baaaaaaaio
87   PMW_PIN[34]   lvc330f080baaaaaaaio
116   PMW_PIN[35]   lvc330f080baaaaaaaio
7   PMW_PIN[36]   lvc330f080baaaaaaaio
90   PMW_PIN[37]   lvc330f080baaaaaaaio
36   PMW_PIN[38]   lvc330f080baaaaaaaio
43   PMW_PIN[39]   lvc330f080baaaaaaaio
142   PMW_PIN[3]   lvc330f080baaaaaaaio
33   PMW_PIN[40]   lvc330f080baaaaaaaio
85   PMW_PIN[41]   lvc330f080baaaaaaaio
67   PMW_PIN[42]   lvc330f080baaaaaaaio
18   PMW_PIN[43]   lvc330f080baaaaaaaio
108   PMW_PIN[44]   lvc330f080baaaaaaaio
25   PMW_PIN[45]   lvc330f080baaaaaaaio
94   PMW_PIN[46]   lvc330f080baaaaaaaio
58   PMW_PIN[47]   lvc330f080baaaaaaaio
95   PMW_PIN[48]   lvc330f080baaaaaaaio
19   PMW_PIN[49]   lvc330f080baaaaaaaio
23   PMW_PIN[4]   lvc330f080baaaaaaaio
3   PMW_PIN[50]   lvc330f080baaaaaaaio
102   PMW_PIN[51]   lvc330f080baaaaaaaio
110   PMW_PIN[52]   lvc330f080baaaaaaaio
92   PMW_PIN[53]   lvc330f080baaaaaaaio
65   PMW_PIN[54]   lvc330f080baaaaaaaio
138   PMW_PIN[55]   lvc330f080baaaaaaaio
126   PMW_PIN[56]   lvc330f080baaaaaaaio
34   PMW_PIN[57]   lvc330f080baaaaaaaio
137   PMW_PIN[58]   lvc330f080baaaaaaaio
15   PMW_PIN[59]   lvc330f080baaaaaaaio
97   PMW_PIN[5]   lvc330f080baaaaaaaio
107   PMW_PIN[60]   lvc330f080baaaaaaaio
45   PMW_PIN[61]   lvc330f080baaaaaaaio
5   PMW_PIN[62]   lvc330f080baaaaaaaio
69   PMW_PIN[63]   lvc330f080baaaaaaaio
1   PMW_PIN[64]   lvc330f080baaaaaaaio
60   PMW_PIN[65]   lvc330f080baaaaaaaio
80   PMW_PIN[66]   lvc330f080baaaaaaaio
62   PMW_PIN[67]   lvc330f080baaaaaaaio
22   PMW_PIN[68]   lvc330f080baaaaaaaio
106   PMW_PIN[69]   lvc330f080baaaaaaaio
20   PMW_PIN[6]   lvc330f080baaaaaaaio
121   PMW_PIN[70]   lvc330f080baaaaaaaio
49   PMW_PIN[71]   lvc330f080baaaaaaaio
73   PMW_PIN[72]   lvc330f080baaaaaaaio
55   PMW_PIN[73]   lvc330f080baaaaaaaio
46   PMW_PIN[74]   lvc330f080baaaaaaaio
76   PMW_PIN[75]   lvc330f080baaaaaaaio
44   PMW_PIN[76]   lvc330f080baaaaaaaio
133   PMW_PIN[77]   lvc330f080baaaaaaaio
32   PMW_PIN[78]   lvc330f080baaaaaaaio
139   PMW_PIN[79]   lvc330f080baaaaaaaio
103   PMW_PIN[7]   lvc330f080baaaaaaaio
125   PMW_PIN[80]   lvc330f080baaaaaaaio
143   PMW_PIN[81]   lvc330f080baaaaaaaio
132   PMW_PIN[82]   lvc330f080baaaaaaaio
30   PMW_PIN[83]   lvc330f080baaaaaaaio
114   PMW_PIN[84]   lvc330f080baaaaaaaio
12   PMW_PIN[85]   lvc330f080baaaaaaaio
57   PMW_PIN[86]   lvc330f080baaaaaaaio
71   PMW_PIN[87]   lvc330f080baaaaaaaio
6   PMW_PIN[88]   lvc330f080baaaaaaaio
75   PMW_PIN[89]   lvc330f080baaaaaaaio
56   PMW_PIN[8]   lvc330f080baaaaaaaio
2   PMW_PIN[90]   lvc330f080baaaaaaaio
41   PMW_PIN[91]   lvc330f080baaaaaaaio
140   PMW_PIN[92]   lvc330f080baaaaaaaio
79   PMW_PIN[93]   lvc330f080baaaaaaaio
84   PMW_PIN[94]   lvc330f080baaaaaaaio
29   PMW_PIN[95]   lvc330f080baaaaaaaio
119   PMW_PIN[9]   lvc330f080baaaaaaaio
109   SPI[0]   lvc330f080baaaaaaaio
14   SPI[1]   lvc330f080baaaaaaaio
127   SPI[2]   lvc330f080baaaaaaaio
48   signal[0]   lvc330f080baaaaaaaio
35   signal[10]   lvc330f080baaaaaaaio
134   signal[11]   lvc330f080baaaaaaaio
74   signal[1]   lvc330f080baaaaaaaio
89   signal[2]   lvc330f080baaaaaaaio
113   signal[3]   lvc330f080baaaaaaaio
120   signal[4]   lvc330f080baaaaaaaio
130   signal[5]   lvc330f080baaaaaaaio
13   signal[6]   lvc330f080baaaaaaaio
31   signal[7]   lvc330f080baaaaaaaio
144   signal[8]   lvc330f080baaaaaaaio
40   signal[9]   lvc330f080baaaaaaaio
| Models and submodels in the file (1): lvc330f080baaaaaaaio (I/O)
